* AC response of all three bands, and their sum.
.include crossover.net
.include models.lib
.include jfet-m5.lib

.control
set filetype=ascii
foreach kfv 0 1
  alter @rvr1a_a[resistance] = 0
  destroy all
  altermod all
  let dummy=0
end
.endc
